* 5-stage CMOS Ring Oscillator — 180nm-ish Level-1
* Self-contained inline NMOS/PMOS Level-1 model cards (no external BSIM4 dependency).
* Vdd is overridden by ngspice -b via .param injection trick; default = 1.8V.
* Circuit is deterministic (method=trap, fixed reltol/abstol) → byte-identical 2-run.
*
* Parameters
*   POSITIVE:  Vdd=1.8V, 5 inverter stages → free oscillation ~8.85 GHz
*   NEGATIVE:  Vdd=0.3V, sub-threshold       → no oscillation (G2 sign-flip)
*
.options noacct nopage temp=27 reltol=1e-4 abstol=1e-12 vntol=1e-6 method=trap
.model NMOS NMOS (LEVEL=1 VTO=0.4 KP=300u LAMBDA=0.05 GAMMA=0.4 PHI=0.7 TOX=4.1n)
.model PMOS PMOS (LEVEL=1 VTO=-0.4 KP=120u LAMBDA=0.05 GAMMA=0.4 PHI=0.7 TOX=4.1n)
Vdd vdd 0 DC __VDD__
* 5 inverter stages: ring topology n5 → inv → n1 → inv → n2 → inv → n3 → inv → n4 → inv → n5
M1n n1 n5 0   0   NMOS L=0.18u W=1u
M1p n1 n5 vdd vdd PMOS L=0.18u W=2u
M2n n2 n1 0   0   NMOS L=0.18u W=1u
M2p n2 n1 vdd vdd PMOS L=0.18u W=2u
M3n n3 n2 0   0   NMOS L=0.18u W=1u
M3p n3 n2 vdd vdd PMOS L=0.18u W=2u
M4n n4 n3 0   0   NMOS L=0.18u W=1u
M4p n4 n3 vdd vdd PMOS L=0.18u W=2u
M5n n5 n4 0   0   NMOS L=0.18u W=1u
M5p n5 n4 vdd vdd PMOS L=0.18u W=2u
* small load capacitances (5 fF each) for realistic stage delay
Cl1 n1 0 5f
Cl2 n2 0 5f
Cl3 n3 0 5f
Cl4 n4 0 5f
Cl5 n5 0 5f
* asymmetric initial conditions to break ring symmetry → guarantee oscillation start
.ic V(n1)=0.0 V(n2)=1.8 V(n3)=0.0 V(n4)=1.8 V(n5)=0.9
.tran 5p 200n 0 5p uic
.print tran V(n1)
.end
